* SOI Inverter
* Mx  Drain Gate Source Back-gate(substrate) Body  Tx  W  L (body ommitted for FB)

.include /Users/Ishwar/Desktop/ML-Spice-2/ngspice-35.prev/examples/soi/bsim4soi/nmos4p0.mod
.include /Users/Ishwar/Desktop/ML-Spice-2/ngspice-35.prev/examples/soi/bsim4soi/pmos4p0.mod
.option TEMP=27C
